# Ansys Electronics Desktop project, version 2023.2
materials:
  vacuum: permittivity=1
  FR4_epoxy: permittivity=4.4 dielectric_loss_tangent=0.02

design Hfssdesign (HFSS, HFSS Hybrid Terminal Network, model units mm)
options: Allow_Material_Override Save_Adaptive_support_files open_region{BoundaryType=0 OpFreq=1.21GHz}
variables:
  # --Antenna Dimensions
  Inner_Width = 0.15cm
  Outer_Width = 2.64cm
  Arm_Length = 2.93cm
  Port_Gap_Width = 0.15cm
  # --Substrate Dimensions
  subH = 0.5cm
  subX = 12cm
  subY = 12cm
  subH1 = -0.16cm
  subH2 = -0.16cm
  hh = -0.16
  h2 = -0.16cm
geometry:
  sub [FR4_epoxy] = box(corner=(-subX/2, -subY/2, 0mm), size=(subX, subY, h2))
  NewObject_WN68XG = polyline((-Inner_Width/2.0, Port_Gap_Width/2.0, 0) (Inner_Width/2.0, Port_Gap_Width/2.0, 0mm))
  arm = polyline((-Outer_Width/2.0, Port_Gap_Width/2.0+Arm_Length, 0mm) (Outer_Width/2.0, Port_Gap_Width/2.0+Arm_Length, 0mm))
  arm.connect(NewObject_WN68XG)
  arm1 = arm.duplicate_around_axis(axis=Z, angle=180deg, total=2)
  port1 = rectangle(corner=(-Inner_Width/2, -Port_Gap_Width/2, 0mm), x_size=Inner_Width, y_size=Port_Gap_Width)
  RadiatingSurface [vacuum] = region(absolute_offset=82.644628mm on all sides)
  Rectangle6 = rectangle(corner=(-8mm, -30.9mm, 0mm), x_size=2mm, y_size=6mm)
  Rectangle7 = rectangle(corner=(8mm, -30.9mm, 0mm), x_size=-2mm, y_size=6mm)
  arm1.subtract(Rectangle6, Rectangle7)
  Rectangle8 = rectangle(corner=(-1mm, -30.9mm, 0mm), x_size=2mm, y_size=6mm)
  arm1.subtract(Rectangle8)
  Rectangle9 = rectangle(corner=(-8mm, 30.9mm, 0mm), x_size=2mm, y_size=-6mm)
  Rectangle10 = rectangle(corner=(8mm, 30.9mm, 0mm), x_size=-2mm, y_size=-6mm)
  Rectangle11 = rectangle(corner=(-1mm, 30.9mm, 0mm), x_size=2mm, y_size=-6mm)
  arm.subtract(Rectangle10, Rectangle11, Rectangle9)
  Rectangle12 = rectangle(corner=(-0.5mm, -6mm, 0mm), x_size=1mm, y_size=4mm)
  arm1.subtract(Rectangle12)
  Rectangle13 = rectangle(corner=(-0.5mm, 2mm, 0mm), x_size=1mm, y_size=4mm)
  arm.subtract(Rectangle13)
  Circle1 = circle(normal=Z, centre=(-6e-05mm, 49.66664mm, 0mm), radius=10mm)
  Circle1.move(0mm, -6mm, 0mm)
  Circle2 = circle(normal=Z, centre=(-6e-05mm, 43.66664mm, 0mm), radius=8.75mm)
  Circle1.subtract(Circle2)
  Circle3 = circle(normal=Z, centre=(0mm, 44mm, 0mm), radius=6mm)
  Circle4 = circle(normal=Z, centre=(0mm, 44mm, 0mm), radius=5mm)
  Circle3.subtract(Circle4)
  Rectangle14 = rectangle(corner=(-1mm, 33.5mm, 0mm), x_size=2.5mm, y_size=6.5mm)
  Rectangle14_1 = Rectangle14.copy()
  Circle1.subtract(Rectangle14_1)
  Circle3.subtract(Rectangle14)
  Circle1.unite(Circle3)
  Circle1_3 = Circle1.duplicate_along_line(step=(0.25209806mm, 36.336537mm, 0mm), total=2)
  Circle1.delete()
  Circle1_3.move(0mm, -26mm, -2mm)
  Circle1_3.move(-60mm, 6mm, 0.4mm)
  Circle1_3.move(20mm, -20mm, 0mm)
  Circle1_3_1, Circle1_3_2 = Circle1_3.duplicate_along_line(step=(0mm, -40mm, 0mm), total=3)
  Circle1_3_1_1, Circle1_3_1_2 = Circle1_3_1.duplicate_along_line(step=(40mm, 0mm, 0mm), total=3)
  Circle1_3_2_1, Circle1_3_2_2 = Circle1_3_2.duplicate_along_line(step=(40mm, 0mm, 0mm), total=3)
  Circle1_3_1_1_1 = Circle1_3_1_1.duplicate_along_line(step=(40mm, 40mm, 0mm), total=2)
  Circle1_3_1_1_1_1 = Circle1_3_1_1_1.duplicate_along_line(step=(-40mm, 0mm, 0mm), total=2)
boundaries and excitations:
  antennaMetal: Perfect E Objects=[arm, arm1]
  AutoOpen1: Radiation Objects=RadiatingSurface
  PerfE6: Perfect E Objects=[Circle1_3_2_2, Circle1_3_2_1, Circle1_3_2, Circle1_3_1_2, Circle1_3_1_1_1_1, Circle1_3_1_1_1, Circle1_3_1_1, Circle1_3_1, Circle1_3]
  arm_T1: Terminal port=1 Edges=arm.edge(at (0, 0.75, 0)) TerminalResistance=50ohm
  1: Lumped Port Faces=port1.face LumpedPortType=Terminal Impedance=50ohm
  reference conductors: arm1
mesh:
  initial mesh: GlobalSurfApproximation{CurvedSurfaceApproxChoice=UseSlider SliderMeshSettings=4}
setups:
  Setup1: HfssDriven Frequency=1.21GHz MaxDeltaS=0.02 MaximumPasses=15 MinimumPasses=1 MinimumConvergedPasses=1 PercentRefinement=30 BasisOrder=1 PortAccuracy=2 DrivenSolverType="Direct Solver" IESolverType=ACA
    sweep FF_Sweep: 0.5GHz to 3GHz, 3 points; Type=Discrete SaveFields
    sweep SParam_Sweep: 0.5GHz to 3GHz, 100 points; Type=Interpolating InterpTolerance=0.5 InterpMaxSolns=250 PassivityErrorTolerance=0.0001
source amplitudes:
  1:1: 1V 0deg
radiation setups:
  3D: Infinite Sphere Theta=0deg..180deg step 2deg Phi=-180deg..180deg step 2deg
  Elevation: Infinite Sphere Theta=-180deg..180deg step 1deg Phi=0deg..90deg step 90deg
  Azimuth: Infinite Sphere Theta=90deg..90deg step 0deg Phi=-180deg..180deg step 1deg
  ATK_2D: Infinite Sphere Theta=-180deg..180deg step 1deg Phi=0deg..90deg step 90deg
  ATK_3D: Infinite Sphere Theta=-180deg..180deg step 2deg Phi=0deg..180deg step 5deg
reports:
  Radiation_Pattern: dB(GainTotal) vs Theta on Setup1 : LastAdaptive, ATK_2D [Phi=all Freq=1.21e+09]
  Input Impedance: St11 on Setup1 : SParam_Sweep [Freq=all]
  Gain Plot 1: dB(GainTotal) vs Phi, Theta on Setup1 : LastAdaptive, 3D [Freq=1.21GHz]
  Terminal S Parameter Plot 2: dB(St(arm_T1,arm_T1)) vs Freq on Setup1 : SParam_Sweep; markers MY1 at y=-10.1485
