# Ansys Electronics Desktop project, version 2023.2
materials:
  vacuum: permittivity=1
  FR4_epoxy: permittivity=4.4 dielectric_loss_tangent=0.02

design Hfssdesign (HFSS, HFSS Hybrid Terminal Network, model units mm)
options: Allow_Material_Override Save_Adaptive_support_files open_region{BoundaryType=0 OpFreq=1.21GHz}
variables:
  # --Antenna Dimensions
  Inner_Width = 0.15cm
  Outer_Width = 2.64cm
  Arm_Length = 2.93cm
  Port_Gap_Width = 0.15cm
  # --Substrate Dimensions
  subH = 0.5cm
  subX = 12cm
  subY = 12cm
  subH1 = -0.16cm
  subH2 = -0.16cm
  hh = -0.16
  h2 = -0.16cm
geometry:
  sub [FR4_epoxy] = box(corner=(-subX/2, -subY/2, 0mm), size=(subX, subY, h2))
  NewObject_WN68XG = polyline((-Inner_Width/2.0, Port_Gap_Width/2.0, 0) (Inner_Width/2.0, Port_Gap_Width/2.0, 0mm))
  arm = polyline((-Outer_Width/2.0, Port_Gap_Width/2.0+Arm_Length, 0mm) (Outer_Width/2.0, Port_Gap_Width/2.0+Arm_Length, 0mm))
  arm.connect(NewObject_WN68XG)
  arm1 = arm.duplicate_around_axis(axis=Z, angle=180deg, total=2)
  port1 = rectangle(corner=(-Inner_Width/2, -Port_Gap_Width/2, 0mm), x_size=Inner_Width, y_size=Port_Gap_Width)
  RadiatingSurface [vacuum] = region(absolute_offset=82.644628mm on all sides)
  Rectangle1 = rectangle(corner=(-63.3334mm, -63.3334mm, (3.2+1.4) mm), x_size=24mm, y_size=24mm)
  Rectangle1_1..Rectangle1_4 = Rectangle1.duplicate_along_line(step=(25.66667mm, 0mm, 0mm), total=5)
  Rectangle1_5..Rectangle1_8 = Rectangle1.duplicate_along_line(step=(0mm, 25.66667mm, 0mm), total=5)
  Rectangle1_5_1..Rectangle1_5_4 = Rectangle1_5.duplicate_along_line(step=(25.66667mm, 0mm, 0mm), total=5)
  Rectangle1_6_1..Rectangle1_6_4 = Rectangle1_6.duplicate_along_line(step=(25.66667mm, 0mm, 0mm), total=5)
  Rectangle1_7_1..Rectangle1_7_4 = Rectangle1_7.duplicate_along_line(step=(25.66667mm, 0mm, 0mm), total=5)
  Rectangle1_8_1..Rectangle1_8_4 = Rectangle1_8.duplicate_along_line(step=(25.66667mm, 0mm, 0mm), total=5)
  [Rectangle1, Rectangle1_1..Rectangle1_8, Rectangle1_5_1..Rectangle1_5_4, Rectangle1_6_1..Rectangle1_6_4, Rectangle1_7_1..Rectangle1_7_4, Rectangle1_8_1..Rectangle1_8_4].move(0mm, 0mm, -40mm)
  [Rectangle1, Rectangle1_1..Rectangle1_8, Rectangle1_5_1..Rectangle1_5_4, Rectangle1_6_1..Rectangle1_6_4, Rectangle1_7_1..Rectangle1_7_4, Rectangle1_8_1..Rectangle1_8_4].move(0mm, 0mm, 30mm)
  [Rectangle1, Rectangle1_1..Rectangle1_8, Rectangle1_5_1..Rectangle1_5_4, Rectangle1_6_1..Rectangle1_6_4, Rectangle1_7_1..Rectangle1_7_4, Rectangle1_8_1..Rectangle1_8_4].move(0mm, 0mm, 3.4mm)
  [Rectangle1, Rectangle1_1..Rectangle1_8, Rectangle1_5_1..Rectangle1_5_4, Rectangle1_6_1..Rectangle1_6_4, Rectangle1_7_1..Rectangle1_7_4, Rectangle1_8_1..Rectangle1_8_4].move(1mm, 0mm, 3mm)
  [Rectangle1, Rectangle1_1..Rectangle1_8, Rectangle1_5_1..Rectangle1_5_4, Rectangle1_6_1..Rectangle1_6_4, Rectangle1_7_1..Rectangle1_7_4, Rectangle1_8_1..Rectangle1_8_4].move(0mm, 0mm, -1.6mm)
  [Rectangle1, Rectangle1_1..Rectangle1_8, Rectangle1_5_1..Rectangle1_5_4, Rectangle1_6_1..Rectangle1_6_4, Rectangle1_7_1..Rectangle1_7_4, Rectangle1_8_1..Rectangle1_8_4].move(0mm, 0mm, -4.4mm)
  [Rectangle1, Rectangle1_1..Rectangle1_8, Rectangle1_5_1..Rectangle1_5_4, Rectangle1_6_1..Rectangle1_6_4, Rectangle1_7_1..Rectangle1_7_4, Rectangle1_8_1..Rectangle1_8_4].move(0mm, 0mm, -4mm)
  [Rectangle1, Rectangle1_1..Rectangle1_8, Rectangle1_5_1..Rectangle1_5_4, Rectangle1_6_1..Rectangle1_6_4, Rectangle1_7_1..Rectangle1_7_4, Rectangle1_8_1..Rectangle1_8_4].move(-1mm, 0mm, -4mm)
  [Rectangle1, Rectangle1_1..Rectangle1_8, Rectangle1_5_1..Rectangle1_5_4, Rectangle1_6_1..Rectangle1_6_4, Rectangle1_7_1..Rectangle1_7_4, Rectangle1_8_1..Rectangle1_8_4].move(0mm, 0mm, -15mm)
  [Rectangle1, Rectangle1_1..Rectangle1_8, Rectangle1_5_1..Rectangle1_5_4, Rectangle1_6_1..Rectangle1_6_4, Rectangle1_7_1..Rectangle1_7_4, Rectangle1_8_1..Rectangle1_8_4].move(0mm, 0mm, 30mm)
  [Rectangle1, Rectangle1_1..Rectangle1_8, Rectangle1_5_1..Rectangle1_5_4, Rectangle1_6_1..Rectangle1_6_4, Rectangle1_7_1..Rectangle1_7_4, Rectangle1_8_1..Rectangle1_8_4].move(0mm, 0mm, -1.6mm)
  [Rectangle1, Rectangle1_1..Rectangle1_8, Rectangle1_5_1..Rectangle1_5_4, Rectangle1_6_1..Rectangle1_6_4, Rectangle1_7_1..Rectangle1_7_4, Rectangle1_8_1..Rectangle1_8_4].move(0mm, 0mm, 1mm)
  [Rectangle1, Rectangle1_1..Rectangle1_8, Rectangle1_5_1..Rectangle1_5_4, Rectangle1_6_1..Rectangle1_6_4, Rectangle1_7_1..Rectangle1_7_4, Rectangle1_8_1..Rectangle1_8_4].move(0mm, 0mm, -2mm)
  [Rectangle1, Rectangle1_1..Rectangle1_8, Rectangle1_5_1..Rectangle1_5_4, Rectangle1_6_1..Rectangle1_6_4, Rectangle1_7_1..Rectangle1_7_4, Rectangle1_8_1..Rectangle1_8_4].move(0mm, 0mm, 1mm)
  [Rectangle1, Rectangle1_1..Rectangle1_8, Rectangle1_5_1..Rectangle1_5_4, Rectangle1_6_1..Rectangle1_6_4, Rectangle1_7_1..Rectangle1_7_4, Rectangle1_8_1..Rectangle1_8_4].move(0mm, 0mm, -2mm)
  Rectangle2 = rectangle(corner=(-60mm, 60mm, -1.6mm), x_size=123.33328mm, y_size=3.33328mm)
  Rectangle2_1 = Rectangle2.copy()
  Rectangle1_8.subtract(Rectangle2_1)
  Rectangle2_2 = Rectangle2.copy()
  Rectangle1_8_1.subtract(Rectangle2_2)
  Rectangle2_3 = Rectangle2.copy()
  Rectangle1_8_2.subtract(Rectangle2_3)
  Rectangle2_4 = Rectangle2.copy()
  Rectangle1_8_3.subtract(Rectangle2_4)
  Rectangle1_8_4.subtract(Rectangle2)
  Rectangle3 = rectangle(corner=(-63.3334mm, 63.33328mm, -1.6mm), x_size=3.3334mm, y_size=-126.73328mm)
  Rectangle3_1 = Rectangle3.copy()
  Rectangle1.subtract(Rectangle3_1)
  Rectangle3_2 = Rectangle3.copy()
  Rectangle1_5.subtract(Rectangle3_2)
  Rectangle3_3 = Rectangle3.copy()
  Rectangle1_6.subtract(Rectangle3_3)
  Rectangle3_4 = Rectangle3.copy()
  Rectangle1_7.subtract(Rectangle3_4)
  Rectangle1_8.subtract(Rectangle3)
  Rectangle4 = rectangle(corner=(-60mm, -63.3334mm, -1.6mm), x_size=120mm, y_size=3.3334mm)
  Rectangle4_1 = Rectangle4.copy()
  Rectangle1.subtract(Rectangle4_1)
  Rectangle4_2 = Rectangle4.copy()
  Rectangle1_1.subtract(Rectangle4_2)
  Rectangle4_3 = Rectangle4.copy()
  Rectangle1_2.subtract(Rectangle4_3)
  Rectangle4_4 = Rectangle4.copy()
  Rectangle1_3.subtract(Rectangle4_4)
  Rectangle1_4.subtract(Rectangle4)
  Rectangle5 = rectangle(corner=(60mm, -63.3334mm, -1.6mm), x_size=3.33328mm, y_size=123.3334mm)
  Rectangle5_1 = Rectangle5.copy()
  Rectangle1_4.subtract(Rectangle5_1)
  Rectangle5_2 = Rectangle5.copy()
  Rectangle1_5_4.subtract(Rectangle5_2)
  Rectangle5_3 = Rectangle5.copy()
  Rectangle1_6_4.subtract(Rectangle5_3)
  Rectangle5_4 = Rectangle5.copy()
  Rectangle1_7_4.subtract(Rectangle5_4)
  Rectangle1_8_4.subtract(Rectangle5)
  Rectangle6 = rectangle(corner=(-8mm, -30.9mm, 0mm), x_size=2mm, y_size=6mm)
  Rectangle7 = rectangle(corner=(8mm, -30.9mm, 0mm), x_size=-2mm, y_size=6mm)
  arm1.subtract(Rectangle6, Rectangle7)
  Rectangle8 = rectangle(corner=(-1mm, -30.9mm, 0mm), x_size=2mm, y_size=6mm)
  arm1.subtract(Rectangle8)
  Rectangle9 = rectangle(corner=(-8mm, 30.9mm, 0mm), x_size=2mm, y_size=-6mm)
  Rectangle10 = rectangle(corner=(8mm, 30.9mm, 0mm), x_size=-2mm, y_size=-6mm)
  Rectangle11 = rectangle(corner=(-1mm, 30.9mm, 0mm), x_size=2mm, y_size=-6mm)
  arm.subtract(Rectangle10, Rectangle11, Rectangle9)
  Rectangle12 = rectangle(corner=(-0.5mm, -6mm, 0mm), x_size=1mm, y_size=4mm)
  arm1.subtract(Rectangle12)
  Rectangle13 = rectangle(corner=(-0.5mm, 2mm, 0mm), x_size=1mm, y_size=4mm)
  arm.subtract(Rectangle13)
boundaries and excitations:
  antennaMetal: Perfect E Objects=[arm, arm1]
  AutoOpen1: Radiation Objects=RadiatingSurface
  PerfE3: Perfect E Objects=[Rectangle1, Rectangle1_1..Rectangle1_8, Rectangle1_5_1..Rectangle1_5_4, Rectangle1_6_1..Rectangle1_6_4, Rectangle1_7_1..Rectangle1_7_4, Rectangle1_8_1..Rectangle1_8_4]
  arm_T1: Terminal port=1 Edges=arm.edge(at (0, 0.75, 0)) TerminalResistance=50ohm
  1: Lumped Port Faces=port1.face LumpedPortType=Terminal Impedance=50ohm
  reference conductors: arm1
setups:
  Setup1: HfssDriven Frequency=1.21GHz MaxDeltaS=0.02 MaximumPasses=15 MinimumPasses=1 MinimumConvergedPasses=1 PercentRefinement=30 BasisOrder=1 PortAccuracy=2 DrivenSolverType="Direct Solver" IESolverType=ACA
    sweep FF_Sweep: 0.5GHz to 3GHz, 3 points; Type=Discrete SaveFields
    sweep SParam_Sweep: 0.5GHz to 3GHz, 100 points; Type=Interpolating InterpTolerance=0.5 InterpMaxSolns=250 PassivityErrorTolerance=0.0001
source amplitudes:
  1:1: 1V 0deg
radiation setups:
  3D: Infinite Sphere Theta=0deg..180deg step 2deg Phi=-180deg..180deg step 2deg
  Elevation: Infinite Sphere Theta=-180deg..180deg step 1deg Phi=0deg..90deg step 90deg
  Azimuth: Infinite Sphere Theta=90deg..90deg step 0deg Phi=-180deg..180deg step 1deg
  ATK_2D: Infinite Sphere Theta=-180deg..180deg step 1deg Phi=0deg..90deg step 90deg
  ATK_3D: Infinite Sphere Theta=-180deg..180deg step 2deg Phi=0deg..180deg step 5deg
reports:
  Radiation_Pattern: dB(GainTotal) vs Theta on Setup1 : LastAdaptive, ATK_2D [Phi=all Freq=1.21e+09]
  Input Impedance: St11 on Setup1 : SParam_Sweep [Freq=all]
  Gain Plot 1: dB(GainTotal) vs Phi, Theta on Setup1 : LastAdaptive, 3D [Freq=1.21GHz]
  Terminal S Parameter Plot 2: dB(St(arm_T1,arm_T1)) vs Freq on Setup1 : SParam_Sweep; markers MY1 at y=-9.83871
